* Four-parallel THS3491 output-stage testbench for Multisim / SPICE
* Model source:
* C:\Users\CaoTX\Downloads\sbomai5a\THS3491DDA.cir
*
* THS3491DDA pin order:
* INP INN OUT REF PD_not VCC VEE GND

.include "C:\Users\CaoTX\Downloads\sbomai5a\THS3491DDA.cir"

.param VPOS=15
.param VNEG=-15
.param RLOAD=50

VCC VCC 0 {VPOS}
VEE VEE 0 {VNEG}
VPD PDN 0 {VPOS}

* Start with small signal. Increase amplitude only after convergence is OK.
VIN IN 0 AC 1 SIN(0 50m 1Meg)

* Approximate the left-side driver as a low-impedance signal source.
RISO IN DRIVE 33

* Channel 1
R1 DRIVE U1P 49.9
R3 U1N 0 2k
R2 U1N U1O 2k
XU1 U1P U1N U1O 0 PDN VCC VEE 0 THS3491DDA
R17 U1O OUT 2.2

* Channel 2
R6 DRIVE U2P 49.9
R4 U2N 0 2k
R5 U2N U2O 2k
XU2 U2P U2N U2O 0 PDN VCC VEE 0 THS3491DDA
R7 U2O OUT 2.2

* Channel 3
R10 DRIVE U3P 49.9
R8 U3N 0 2k
R9 U3N U3O 2k
XU3 U3P U3N U3O 0 PDN VCC VEE 0 THS3491DDA
R11 U3O OUT 2.2

* Channel 4
R14 DRIVE U4P 49.9
R12 U4N 0 2k
R13 U4N U4O 2k
XU4 U4P U4N U4O 0 PDN VCC VEE 0 THS3491DDA
R15 U4O OUT 2.2

RLOAD OUT 0 {RLOAD}

.ac dec 100 1k 100Meg
.tran 0 20u 0 1n

.probe V(IN) V(DRIVE) V(OUT)
.end
